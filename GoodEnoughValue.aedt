# Ansys Electronics Desktop project, version 2025.2
project variables:
  $W = 15um  # CPW conductor width
  $s = 9um  # CPW gap
  $sample_width = 1mm
  $sample_length = 2mm
  $sample_thickness = 750um
  $delta_length = 700um
  $gap = 25um  # Center-to-centre distance between CPW conductors
materials:
  vacuum: permittivity=1
  silicon: permittivity=11.9

design HFSSDesign1 (HFSS, HFSS Modal Network, model units mm)
variables:
  W = 2mm
geometry:
  Bottom_gnd = rectangle(corner=(-$sample_length/2, -2mm, 0mm), x_size=$sample_length, y_size=1.9835mm)
  Box2 [silicon] = box(corner=(-$sample_length/2, 0.5mm, -0.75mm), size=($sample_length, -2.5mm, $sample_thickness))
  Rectangle3 = rectangle(corner=(-$sample_length/2, $s+$W/2, 0mm), x_size=$sample_length, y_size=$sample_width/2-$W/2-$s)
  Rectangle4 = rectangle(corner=(-$sample_length/2, -($sample_width-0.5mm)/2, -0.75mm), y_size=$sample_width-0.5mm, z_size=1.25mm)
  Rectangle5 = rectangle(corner=($sample_length/2, -($sample_width-0.5mm)/2, -0.75mm), y_size=($sample_width-0.5mm), z_size=1.25mm)
  Box3 [vacuum] = box(corner=(-$sample_length/2, 2mm, -0.75mm), size=($sample_length, -5.5mm, 1.25mm))
  cut_resonator5 = polyline((-0.0004-$s-$W/2, -0.0010+25um-$gap, 0) (-0.0004+$s+$W/2, -0.001+25um-$gap, 0))
  cut_resonator_path5 = polyline(z=0, xy: (-0.0004, -0.001+25um-$gap) (-0.0004, -0.0006+25um-$gap) (-0.00017820834, -0.0006+25um-$gap) (-0.00017820834, -0.0004+25um-$gap) (-0.00062179166, -0.0004+25um-$gap) (-0.00062179166, -0.0002+25um-$gap) (-0.00017820834, -0.0002+25um-$gap) (-0.00017820834, -0.0000+25um-$gap) (-0.00062179166, -0.0000+25um-$gap) (-0.00062179166, 0.0002+25um-$gap) (-0.00017820834, 0.0002+25um-$gap) (-0.00017820834, 0.0004+25um-$gap) (-0.00039, 0.0004+25um-$gap) (-0.00039, 0.000774+25um-$gap) (0.0004, 0.000774+25um-$gap) (0.0004, 0.00020512+25um-$gap-$delta_length))
  cut_resonator_path5.fillet(Vertices=cut_resonator_path5.vertex(at (-0.4, -0.6, 0), at (-0.178208, -0.6, 0), at (-0.178208, -0.4, 0), at (-0.621792, -0.4, 0), at (-0.621792, -0.2, 0), at (-0.178208, -0.2, 0), at (-0.178208, 0, 0), at (-0.621792, 0, 0), at (-0.621792, 0.2, 0), at (-0.178208, 0.2, 0), at (-0.178208, 0.4, 0), at (-0.39, 0.4, 0)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) Radius=9e-05 Setback=0mm)
  cut_resonator5.sweep_along_path(cut_resonator_path5)
  cut_resonator5.move(0mm, -0.02mm, 0mm)
  cut_resonator5.move(0mm, 0mm, 0mm)
  cut_resonator5.move(0mm, 0.013mm, 0mm)
  cut_resonator5.move(0mm, -0.78mm, 0mm)
  cut_resonator5.move(0mm, 0.01mm, 0mm)
  cut_resonator5.move(0mm, -0.04mm, 0mm)
  Bottom_gnd.subtract(cut_resonator5)
  cut_resonator6 = polyline((-0.0004-$s-$W/2, -0.0010+25um-$gap, 0) (-0.0004+$s+$W/2, -0.001+25um-$gap, 0))
  cut_resonator_path6 = polyline(z=0, xy: (-0.0004, -0.001+25um-$gap) (-0.0004, -0.0006+25um-$gap) (-0.00017820834, -0.0006+25um-$gap) (-0.00017820834, -0.0004+25um-$gap) (-0.00062179166, -0.0004+25um-$gap) (-0.00062179166, -0.0002+25um-$gap) (-0.00017820834, -0.0002+25um-$gap) (-0.00017820834, -0.0000+25um-$gap) (-0.00062179166, -0.0000+25um-$gap) (-0.00062179166, 0.0002+25um-$gap) (-0.00017820834, 0.0002+25um-$gap) (-0.00017820834, 0.0004+25um-$gap) (-0.00039, 0.0004+25um-$gap) (-0.00039, 0.000774+25um-$gap) (0.0004, 0.000774+25um-$gap) (0.0004, 0.00020512+25um-$gap-$delta_length))
  cut_resonator_path6.fillet(Vertices=cut_resonator_path6.vertex(at (-0.4, -0.6, 0), at (-0.178208, -0.6, 0), at (-0.178208, -0.4, 0), at (-0.621792, -0.4, 0), at (-0.621792, -0.2, 0), at (-0.178208, -0.2, 0), at (-0.178208, 0, 0), at (-0.621792, 0, 0), at (-0.621792, 0.2, 0), at (-0.178208, 0.2, 0), at (-0.178208, 0.4, 0), at (-0.39, 0.4, 0)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) Radius=9e-05 Setback=0mm)
  cut_resonator6.sweep_along_path(cut_resonator_path6)
  cut_resonator6.move(0mm, -0.02mm, 0mm)
  cut_resonator6.move(0mm, 0mm, 0mm)
  cut_resonator6.move(0mm, 0.013mm, 0mm)
  cut_resonator6.move(0mm, -0.78mm, 0mm)
  cut_resonator6.move(0mm, 0.01mm, 0mm)
  cut_resonator6.move(0mm, -0.04mm, 0mm)
  cut_resonator7 = polyline((-0.0004-$s-$W/2, -0.0010+25um-$gap, 0) (-0.0004+$s+$W/2, -0.001+25um-$gap, 0))
  cut_resonator_path7 = polyline(z=0, xy: (-0.0004, -0.001+25um-$gap) (-0.0004, -0.0006+25um-$gap) (-0.00017820834, -0.0006+25um-$gap) (-0.00017820834, -0.0004+25um-$gap) (-0.00062179166, -0.0004+25um-$gap) (-0.00062179166, -0.0002+25um-$gap) (-0.00017820834, -0.0002+25um-$gap) (-0.00017820834, -0.0000+25um-$gap) (-0.00062179166, -0.0000+25um-$gap) (-0.00062179166, 0.0002+25um-$gap) (-0.00017820834, 0.0002+25um-$gap) (-0.00017820834, 0.0004+25um-$gap) (-0.00039, 0.0004+25um-$gap) (-0.00039, 0.000774+25um-$gap) (0.0004, 0.000774+25um-$gap) (0.0004, 0.00020512+25um-$gap-$delta_length))
  cut_resonator_path7.fillet(Vertices=cut_resonator_path7.vertex(at (-0.4, -0.6, 0), at (-0.178208, -0.6, 0), at (-0.178208, -0.4, 0), at (-0.621792, -0.4, 0), at (-0.621792, -0.2, 0), at (-0.178208, -0.2, 0), at (-0.178208, 0, 0), at (-0.621792, 0, 0), at (-0.621792, 0.2, 0), at (-0.178208, 0.2, 0), at (-0.178208, 0.4, 0), at (-0.39, 0.4, 0)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) Radius=9e-05 Setback=0mm)
  cut_resonator7.sweep_along_path(cut_resonator_path7)
  cut_resonator7.move(0mm, -0.02mm, 0mm)
  cut_resonator7.move(0mm, 0mm, 0mm)
  cut_resonator7.move(0mm, 0.013mm, 0mm)
  cut_resonator7.move(0mm, -0.78mm, 0mm)
  cut_resonator7.move(0mm, 0.01mm, 0mm)
  cut_resonator7.move(0mm, -0.04mm, 0mm)
  Bottom_gnd.unite(cut_resonator7)
  cut_resonator6.move(0mm, 0.01mm, 0mm)
  Bottom_gnd.subtract(cut_resonator6)
  cut_resonator8 = polyline((-0.0004-$s-$W/2, -0.0010+25um-$gap, 0) (-0.0004+$s+$W/2, -0.001+25um-$gap, 0))
  cut_resonator_path8 = polyline(z=0, xy: (-0.0004, -0.001+25um-$gap) (-0.0004, -0.0006+25um-$gap) (-0.00017820834, -0.0006+25um-$gap) (-0.00017820834, -0.0004+25um-$gap) (-0.00062179166, -0.0004+25um-$gap) (-0.00062179166, -0.0002+25um-$gap) (-0.00017820834, -0.0002+25um-$gap) (-0.00017820834, -0.0000+25um-$gap) (-0.00062179166, -0.0000+25um-$gap) (-0.00062179166, 0.0002+25um-$gap) (-0.00017820834, 0.0002+25um-$gap) (-0.00017820834, 0.0004+25um-$gap) (-0.00039, 0.0004+25um-$gap) (-0.00039, 0.000774+25um-$gap) (0.0004, 0.000774+25um-$gap) (0.0004, 0.00020512+25um-$gap-$delta_length))
  cut_resonator_path8.fillet(Vertices=cut_resonator_path8.vertex(at (-0.4, -0.6, 0), at (-0.178208, -0.6, 0), at (-0.178208, -0.4, 0), at (-0.621792, -0.4, 0), at (-0.621792, -0.2, 0), at (-0.178208, -0.2, 0), at (-0.178208, 0, 0), at (-0.621792, 0, 0), at (-0.621792, 0.2, 0), at (-0.178208, 0.2, 0), at (-0.178208, 0.4, 0), at (-0.39, 0.4, 0)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) Radius=9e-05 Setback=0mm)
  cut_resonator8.sweep_along_path(cut_resonator_path8)
  cut_resonator8.move(0mm, -0.02mm, 0mm)
  cut_resonator8.move(0mm, 0mm, 0mm)
  cut_resonator8.move(0mm, 0.013mm, 0mm)
  cut_resonator8.move(0mm, -0.78mm, 0mm)
  cut_resonator8.move(0mm, 0.01mm, 0mm)
  cut_resonator8.move(0mm, -0.04mm, 0mm)
  cut_resonator8.move(0mm, 0.01mm, 0mm)
  cut_resonator9 = polyline((-0.0004-$s-$W/2, -0.0010+25um-$gap, 0) (-0.0004+$s+$W/2, -0.001+25um-$gap, 0))
  cut_resonator_path9 = polyline(z=0, xy: (-0.0004, -0.001+25um-$gap) (-0.0004, -0.0006+25um-$gap) (-0.00017820834, -0.0006+25um-$gap) (-0.00017820834, -0.0004+25um-$gap) (-0.00062179166, -0.0004+25um-$gap) (-0.00062179166, -0.0002+25um-$gap) (-0.00017820834, -0.0002+25um-$gap) (-0.00017820834, -0.0000+25um-$gap) (-0.00062179166, -0.0000+25um-$gap) (-0.00062179166, 0.0002+25um-$gap) (-0.00017820834, 0.0002+25um-$gap) (-0.00017820834, 0.0004+25um-$gap) (-0.00039, 0.0004+25um-$gap) (-0.00039, 0.000774+25um-$gap) (0.0004, 0.000774+25um-$gap) (0.0004, 0.00020512+25um-$gap-$delta_length))
  cut_resonator_path9.fillet(Vertices=cut_resonator_path9.vertex(at (-0.4, -0.6, 0), at (-0.178208, -0.6, 0), at (-0.178208, -0.4, 0), at (-0.621792, -0.4, 0), at (-0.621792, -0.2, 0), at (-0.178208, -0.2, 0), at (-0.178208, 0, 0), at (-0.621792, 0, 0), at (-0.621792, 0.2, 0), at (-0.178208, 0.2, 0), at (-0.178208, 0.4, 0), at (-0.39, 0.4, 0)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) Radius=9e-05 Setback=0mm)
  cut_resonator9.sweep_along_path(cut_resonator_path9)
  cut_resonator9.move(0mm, -0.02mm, 0mm)
  cut_resonator9.move(0mm, 0mm, 0mm)
  cut_resonator9.move(0mm, 0.013mm, 0mm)
  cut_resonator9.move(0mm, -0.78mm, 0mm)
  cut_resonator9.move(0mm, 0.01mm, 0mm)
  cut_resonator9.move(0mm, -0.04mm, 0mm)
  cut_resonator9.move(0mm, 0.01mm, 0mm)
  Rectangle7 = rectangle(corner=(0.31mm, -0.0165mm, 0mm), x_size=-0.4157mm, y_size=-0.033mm)
  Rectangle7_1 = Rectangle7.copy()
  cut_resonator8.subtract(Rectangle7_1)
  Rectangle7_2 = Rectangle7.copy()
  Rectangle7.delete()
  cut_resonator9.subtract(Rectangle7_2)
  cut_resonator8_Separate1 = cut_resonator8.separate_bodies()
  cut_resonator9_Separate1 = cut_resonator9.separate_bodies()
  [cut_resonator8_Separate1, cut_resonator9_Separate1].move(-0.4157mm, 0mm, 0mm)
  cut_resonator9_Separate1.unite(cut_resonator9)
  cut_resonator8_Separate1.unite(cut_resonator8)
  Bottom_gnd.unite(cut_resonator9_Separate1)
  cut_resonator10 = polyline((-0.0004-$s-$W/2, -0.0010+25um-$gap, 0) (-0.0004+$s+$W/2, -0.001+25um-$gap, 0))
  cut_resonator_path10 = polyline(z=0, xy: (-0.0004, -0.001+25um-$gap) (-0.0004, -0.0006+25um-$gap) (-0.00017820834, -0.0006+25um-$gap) (-0.00017820834, -0.0004+25um-$gap) (-0.00062179166, -0.0004+25um-$gap) (-0.00062179166, -0.0002+25um-$gap) (-0.00017820834, -0.0002+25um-$gap) (-0.00017820834, -0.0000+25um-$gap) (-0.00062179166, -0.0000+25um-$gap) (-0.00062179166, 0.0002+25um-$gap) (-0.00017820834, 0.0002+25um-$gap) (-0.00017820834, 0.0004+25um-$gap) (-0.00039, 0.0004+25um-$gap) (-0.00039, 0.000774+25um-$gap) (0.0004, 0.000774+25um-$gap) (0.0004, 0.00020512+25um-$gap-$delta_length))
  cut_resonator_path10.fillet(Vertices=cut_resonator_path10.vertex(at (-0.4, -0.6, 0), at (-0.178208, -0.6, 0), at (-0.178208, -0.4, 0), at (-0.621792, -0.4, 0), at (-0.621792, -0.2, 0), at (-0.178208, -0.2, 0), at (-0.178208, 0, 0), at (-0.621792, 0, 0), at (-0.621792, 0.2, 0), at (-0.178208, 0.2, 0), at (-0.178208, 0.4, 0), at (-0.39, 0.4, 0)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) Radius=9e-05 Setback=0mm)
  cut_resonator10.sweep_along_path(cut_resonator_path10)
  cut_resonator10.move(0mm, -0.02mm, 0mm)
  cut_resonator10.move(0mm, 0mm, 0mm)
  cut_resonator10.move(0mm, 0.013mm, 0mm)
  cut_resonator10.move(0mm, -0.78mm, 0mm)
  cut_resonator10.move(0mm, 0.01mm, 0mm)
  cut_resonator10.move(0mm, -0.04mm, 0mm)
  cut_resonator10.move(0mm, 0.01mm, 0mm)
  Bottom_gnd.unite(cut_resonator10)
  Bottom_gnd.subtract(cut_resonator8_Separate1)
  Rectangle8 = rectangle(corner=(-$sample_length/2, -$W/2, 0mm), x_size=$sample_length, y_size=$W)
  Rectangle8.separate_bodies()
  Rectangle10 = rectangle(corner=(-0.55mm, -0.5mm, 0mm), x_size=0.45mm, y_size=0.2mm)
  Bottom_gnd.subtract(Rectangle10)
  cut_resonator11 = polyline((-0.0004-$s-$W/2, -0.0010+25um-$gap, 0) (-0.0004+$s+$W/2, -0.001+25um-$gap, 0))
  cut_resonator_path11 = polyline(z=0, xy: (-0.0004, -0.001+25um-$gap) (-0.0004, -0.0006+25um-$gap) (-0.00017820834, -0.0006+25um-$gap) (-0.00017820834, -0.0004+25um-$gap) (-0.00062179166, -0.0004+25um-$gap) (-0.00062179166, -0.0002+25um-$gap) (-0.00017820834, -0.0002+25um-$gap) (-0.00017820834, -0.0000+25um-$gap) (-0.00062179166, -0.0000+25um-$gap) (-0.00062179166, 0.0002+25um-$gap) (-0.00017820834, 0.0002+25um-$gap) (-0.00017820834, 0.0004+25um-$gap) (-0.00039, 0.0004+25um-$gap) (-0.00039, 0.000774+25um-$gap) (0.0004, 0.000774+25um-$gap) (0.0004, 0.00020512+25um-$gap-$delta_length))
  cut_resonator_path11.fillet(Vertices=cut_resonator_path11.vertex(at (-0.4, -0.6, 0), at (-0.178208, -0.6, 0), at (-0.178208, -0.4, 0), at (-0.621792, -0.4, 0), at (-0.621792, -0.2, 0), at (-0.178208, -0.2, 0), at (-0.178208, 0, 0), at (-0.621792, 0, 0), at (-0.621792, 0.2, 0), at (-0.178208, 0.2, 0), at (-0.178208, 0.4, 0), at (-0.39, 0.4, 0)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) Radius=9e-05 Setback=0mm)
  cut_resonator11.sweep_along_path(cut_resonator_path11)
  cut_resonator11.move(0mm, -0.02mm, 0mm)
  cut_resonator11.move(0mm, 0mm, 0mm)
  cut_resonator11.move(0mm, 0.013mm, 0mm)
  cut_resonator11.move(0mm, -0.78mm, 0mm)
  cut_resonator11.move(0mm, 0.01mm, 0mm)
  cut_resonator11.move(0mm, -0.04mm, 0mm)
  cut_resonator11.move(0mm, 0.01mm, 0mm)
  Rectangle11 = rectangle(corner=(0.31mm, -0.0165mm, 0mm), x_size=-0.4157mm, y_size=-0.033mm)
  Rectangle7_3 = Rectangle11.copy()
  cut_resonator11.subtract(Rectangle7_3)
  cut_resonator8_Separate2 = cut_resonator11.separate_bodies()
  Rectangle11.delete()
  cut_resonator8_Separate2.move(-0.4157mm, 0mm, 0mm)
  cut_resonator8_Separate2.unite(cut_resonator11)
  cut_resonator12 = polyline((-0.0004-$s-$W/2, -0.0010+25um-$gap, 0) (-0.0004+$s+$W/2, -0.001+25um-$gap, 0))
  cut_resonator_path12 = polyline(z=0, xy: (-0.0004, -0.001+25um-$gap) (-0.0004, -0.0006+25um-$gap) (-0.00017820834, -0.0006+25um-$gap) (-0.00017820834, -0.0004+25um-$gap) (-0.00062179166, -0.0004+25um-$gap) (-0.00062179166, -0.0002+25um-$gap) (-0.00017820834, -0.0002+25um-$gap) (-0.00017820834, -0.0000+25um-$gap) (-0.00062179166, -0.0000+25um-$gap) (-0.00062179166, 0.0002+25um-$gap) (-0.00017820834, 0.0002+25um-$gap) (-0.00017820834, 0.0004+25um-$gap) (-0.00039, 0.0004+25um-$gap) (-0.00039, 0.000774+25um-$gap) (0.0004, 0.000774+25um-$gap) (0.0004, 0.00020512+25um-$gap-$delta_length))
  cut_resonator_path12.fillet(Vertices=cut_resonator_path12.vertex(at (-0.4, -0.6, 0), at (-0.178208, -0.6, 0), at (-0.178208, -0.4, 0), at (-0.621792, -0.4, 0), at (-0.621792, -0.2, 0), at (-0.178208, -0.2, 0), at (-0.178208, 0, 0), at (-0.621792, 0, 0), at (-0.621792, 0.2, 0), at (-0.178208, 0.2, 0), at (-0.178208, 0.4, 0), at (-0.39, 0.4, 0)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) Radius=9e-05 Setback=0mm)
  cut_resonator12.sweep_along_path(cut_resonator_path12)
  cut_resonator12.move(0mm, -0.02mm, 0mm)
  cut_resonator12.move(0mm, 0mm, 0mm)
  cut_resonator12.move(0mm, 0.013mm, 0mm)
  cut_resonator12.move(0mm, -0.78mm, 0mm)
  cut_resonator12.move(0mm, 0.01mm, 0mm)
  cut_resonator12.move(0mm, -0.04mm, 0mm)
  cut_resonator12.move(0mm, 0.01mm, 0mm)
  Rectangle12 = rectangle(corner=(0.31mm, -0.0165mm, 0mm), x_size=-0.4157mm, y_size=-0.033mm)
  Rectangle7_4 = Rectangle12.copy()
  cut_resonator12.subtract(Rectangle7_4)
  cut_resonator8_Separate3 = cut_resonator12.separate_bodies()
  Rectangle12.delete()
  cut_resonator8_Separate3.move(-0.4157mm, 0mm, 0mm)
  cut_resonator8_Separate3.unite(cut_resonator12)
  Rectangle13 = rectangle(corner=(-0.55mm, -0.5mm, 0mm), x_size=0.45mm, y_size=0.2mm)
  Rectangle13_1 = Rectangle13.copy()
  cut_resonator8_Separate2.subtract(Rectangle13_1)
  cut_resonator8_Separate3.subtract(Rectangle13)
  cut_resonator8_Separate2_Separate1 = cut_resonator8_Separate2.separate_bodies()
  cut_resonator8_Separate3_Separate1 = cut_resonator8_Separate3.separate_bodies()
  [cut_resonator8_Separate3_Separate1, cut_resonator8_Separate2_Separate1].move(-0.211791663mm, 0.2mm, 0mm)
  cut_resonator8_Separate2.unite(cut_resonator8_Separate2_Separate1)
  cut_resonator8_Separate3.unite(cut_resonator8_Separate3_Separate1)
  cut_resonator13 = polyline((-0.0004-$s-$W/2, -0.0010+25um-$gap, 0) (-0.0004+$s+$W/2, -0.001+25um-$gap, 0))
  cut_resonator_path13 = polyline(z=0, xy: (-0.0004, -0.001+25um-$gap) (-0.0004, -0.0006+25um-$gap) (-0.00017820834, -0.0006+25um-$gap) (-0.00017820834, -0.0004+25um-$gap) (-0.00062179166, -0.0004+25um-$gap) (-0.00062179166, -0.0002+25um-$gap) (-0.00017820834, -0.0002+25um-$gap) (-0.00017820834, -0.0000+25um-$gap) (-0.00062179166, -0.0000+25um-$gap) (-0.00062179166, 0.0002+25um-$gap) (-0.00017820834, 0.0002+25um-$gap) (-0.00017820834, 0.0004+25um-$gap) (-0.00039, 0.0004+25um-$gap) (-0.00039, 0.000774+25um-$gap) (0.0004, 0.000774+25um-$gap) (0.0004, 0.00020512+25um-$gap-$delta_length))
  cut_resonator_path13.fillet(Vertices=cut_resonator_path13.vertex(at (-0.4, -0.6, 0), at (-0.178208, -0.6, 0), at (-0.178208, -0.4, 0), at (-0.621792, -0.4, 0), at (-0.621792, -0.2, 0), at (-0.178208, -0.2, 0), at (-0.178208, 0, 0), at (-0.621792, 0, 0), at (-0.621792, 0.2, 0), at (-0.178208, 0.2, 0), at (-0.178208, 0.4, 0), at (-0.39, 0.4, 0)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) Radius=9e-05 Setback=0mm)
  cut_resonator13.sweep_along_path(cut_resonator_path13)
  cut_resonator13.move(0mm, -0.02mm, 0mm)
  cut_resonator13.move(0mm, 0mm, 0mm)
  cut_resonator13.move(0mm, 0.013mm, 0mm)
  cut_resonator13.move(0mm, -0.78mm, 0mm)
  cut_resonator13.move(0mm, 0.01mm, 0mm)
  cut_resonator13.move(0mm, -0.04mm, 0mm)
  cut_resonator13.move(0mm, 0.01mm, 0mm)
  Rectangle14 = rectangle(corner=(0.31mm, -0.0165mm, 0mm), x_size=-0.4157mm, y_size=-0.033mm)
  Rectangle7_5 = Rectangle14.copy()
  cut_resonator13.subtract(Rectangle7_5)
  cut_resonator8_Separate4 = cut_resonator13.separate_bodies()
  Rectangle14.delete()
  cut_resonator8_Separate4.move(-0.4157mm, 0mm, 0mm)
  cut_resonator8_Separate4.unite(cut_resonator13)
  Rectangle15 = rectangle(corner=(-0.55mm, -0.5mm, 0mm), x_size=0.45mm, y_size=0.2mm)
  Bottom_gnd.unite(Rectangle15)
  Bottom_gnd.unite(cut_resonator8_Separate4)
  Bottom_gnd.subtract(cut_resonator8_Separate2)
  trace_resonator1 = polyline((-0.0004-$W/2, -0.001+25um-$gap, 0) (-0.0004+$W/2, -0.001+25um-$gap, 0))
  trace_resonator_path1 = polyline(z=0, xy: (-0.0004, -0.001+25um-$gap) (-0.0004, -0.0006+25um-$gap) (-0.00017820834, -0.0006+25um-$gap) (-0.00017820834, -0.0004+25um-$gap) (-0.00062179166, -0.0004+25um-$gap) (-0.00062179166, -0.0002+25um-$gap) (-0.00017820834, -0.0002+25um-$gap) (-0.00017820834, -0+25um-$gap) (-0.00062179166, 0+25um-$gap) (-0.00062179166, 0.0002+25um-$gap) (-0.00017820834, 0.0002+25um-$gap) (-0.00017820834, 0.0004+25um-$gap) (-0.00039, 0.0004+25um-$gap) (-0.00039, 0.000774+25um-$gap) (0.0004, 0.000774+25um-$gap) (0.0004, 0.00020512+25um-$gap-$delta_length))
  trace_resonator_path1.fillet(Vertices=trace_resonator_path1.vertex(at (-0.4, -0.6, 0), at (-0.178208, -0.6, 0), at (-0.178208, -0.4, 0), at (-0.621792, -0.4, 0), at (-0.621792, -0.2, 0), at (-0.178208, -0.2, 0), at (-0.178208, 0, 0), at (-0.621792, 0, 0), at (-0.621792, 0.2, 0), at (-0.178208, 0.2, 0), at (-0.178208, 0.4, 0), at (-0.39, 0.4, 0)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) Radius=9e-05 Setback=0mm)
  trace_resonator1.sweep_along_path(trace_resonator_path1)
  trace_resonator1.move(0mm, -0.02mm, 0mm)
  Rectangle16 = rectangle(corner=(0.4mm-$s-$W/2, 0.20512mm+25um-$gap-$delta_length, 0mm), x_size=2*$s+$W, y_size=-0.006mm)
  Rectangle16.move(0mm, -0.014mm, 0mm)
  trace_resonator1.subtract(Rectangle16)
  trace_resonator1.move(0mm, 0.013mm, 0mm)
  trace_resonator1.move(-0.005mm, -0.8095mm, 0mm)
  trace_resonator1.move(0.005mm, 0mm, 0mm)
  trace_resonator1.move(1.110223e-16mm, -0.0005mm, 0mm)
  trace_resonator1.move(0mm, 0.01mm, 0mm)
  Rectangle17 = rectangle(corner=(0.31mm, -0.0165mm, 0mm), x_size=-0.4157mm, y_size=-0.033mm)
  trace_resonator1.subtract(Rectangle17)
  trace_resonator_Separate3 = trace_resonator1.separate_bodies()
  trace_resonator_Separate3.move(-0.4mm, 0mm, 0mm)
  trace_resonator_Separate3.move(0mm, 0mm, 0mm)
  trace_resonator_Separate3.move(-0.0157mm, 1.4571677e-16mm, 0mm)
  trace_resonator1.unite(trace_resonator_Separate3)
  Rectangle18 = rectangle(corner=(-0.55mm, -0.5mm, 0mm), x_size=0.45mm, y_size=0.2mm)
  trace_resonator1.subtract(Rectangle18)
  trace_resonator_Separate4 = trace_resonator1.separate_bodies()
  trace_resonator_Separate4.move(-0.211791663mm, 0.2mm, 0mm)
  trace_resonator1.unite(trace_resonator_Separate4)
  Rectangle19 = rectangle(corner=(-0.3mm, -0.05mm, 0mm), x_size=0.1943mm, y_size=0.0335mm)
  Rectangle20 = rectangle(corner=(-0.3mm, -0.05mm, 0mm), x_size=0.1943mm, y_size=0.0335mm)
  Rectangle20_1 = Rectangle20.copy()
  cut_resonator8_Separate3.subtract(Rectangle20_1)
  trace_resonator1.subtract(Rectangle20)
  Bottom_gnd.unite(Rectangle19)
  cut_resonator8_Separate3_Separate2 = cut_resonator8_Separate3.separate_bodies()
  cut_resonator8_Separate3_Separate2.move(0.1943mm, -2.289835e-16mm, 0mm)
  trace_resonator1_Separate1 = trace_resonator1.separate_bodies()
  trace_resonator1_Separate1.move(0.1943mm, -9.0205621e-17mm, 0mm)
  cut_resonator8_Separate3_Separate2.unite(cut_resonator8_Separate3)
  trace_resonator1_Separate1.unite(trace_resonator1)
  trace_resonator1_Separate1.separate_bodies()
  cut_resonator14 = polyline((-0.0004-$s-$W/2, -0.0010+25um-$gap, 0) (-0.0004+$s+$W/2, -0.001+25um-$gap, 0))
  cut_resonator_path14 = polyline(z=0, xy: (-0.0004, -0.001+25um-$gap) (-0.0004, -0.0006+25um-$gap) (-0.00017820834, -0.0006+25um-$gap) (-0.00017820834, -0.0004+25um-$gap) (-0.00062179166, -0.0004+25um-$gap) (-0.00062179166, -0.0002+25um-$gap) (-0.00017820834, -0.0002+25um-$gap) (-0.00017820834, -0.0000+25um-$gap) (-0.00062179166, -0.0000+25um-$gap) (-0.00062179166, 0.0002+25um-$gap) (-0.00017820834, 0.0002+25um-$gap) (-0.00017820834, 0.0004+25um-$gap) (-0.00039, 0.0004+25um-$gap) (-0.00039, 0.000774+25um-$gap) (0.0004, 0.000774+25um-$gap) (0.0004, 0.00020512+25um-$gap-$delta_length))
  cut_resonator_path14.fillet(Vertices=cut_resonator_path14.vertex(at (-0.4, -0.6, 0), at (-0.178208, -0.6, 0), at (-0.178208, -0.4, 0), at (-0.621792, -0.4, 0), at (-0.621792, -0.2, 0), at (-0.178208, -0.2, 0), at (-0.178208, 0, 0), at (-0.621792, 0, 0), at (-0.621792, 0.2, 0), at (-0.178208, 0.2, 0), at (-0.178208, 0.4, 0), at (-0.39, 0.4, 0)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) Radius=9e-05 Setback=0mm)
  cut_resonator14.sweep_along_path(cut_resonator_path14)
  cut_resonator14.move(0mm, -0.02mm, 0mm)
  cut_resonator14.move(0mm, 0mm, 0mm)
  cut_resonator14.move(0mm, 0.013mm, 0mm)
  cut_resonator14.move(0mm, -0.78mm, 0mm)
  cut_resonator14.move(0mm, 0.01mm, 0mm)
  cut_resonator14.move(0mm, -0.04mm, 0mm)
  cut_resonator14.move(0mm, 0.01mm, 0mm)
  Rectangle21 = rectangle(corner=(0.31mm, -0.0165mm, 0mm), x_size=-0.4157mm, y_size=-0.033mm)
  Rectangle7_6 = Rectangle21.copy()
  cut_resonator14.subtract(Rectangle7_6)
  cut_resonator8_Separate5 = cut_resonator14.separate_bodies()
  Rectangle21.delete()
  cut_resonator8_Separate5.move(-0.4157mm, 0mm, 0mm)
  cut_resonator8_Separate5.unite(cut_resonator14)
  Rectangle22 = rectangle(corner=(-0.55mm, -0.5mm, 0mm), x_size=0.45mm, y_size=0.2mm)
  Rectangle13_2 = Rectangle22.copy()
  cut_resonator8_Separate5.subtract(Rectangle13_2)
  Rectangle22.delete()
  cut_resonator8_Separate2_Separate2 = cut_resonator8_Separate5.separate_bodies()
  cut_resonator8_Separate2_Separate2.move(-0.211791663mm, 0.2mm, 0mm)
  cut_resonator8_Separate5.unite(cut_resonator8_Separate2_Separate2)
  Bottom_gnd.unite(cut_resonator8_Separate5)
  Bottom_gnd.subtract(cut_resonator8_Separate3_Separate2)
  Rectangle23 = rectangle(corner=(-0.21mm, -0.05mm, 0mm), x_size=0.21mm, y_size=0.04mm)
  Bottom_gnd.subtract(Rectangle23)
  Rectangle24 = rectangle(corner=(-0.21mm, -0.05mm, 0mm), x_size=0.03mm, y_size=-0.07mm)
  Bottom_gnd.subtract(Rectangle24)
  Rectangle25 = rectangle(corner=(-0.21164857mm, -0.11217641mm, 0mm), x_size=0.0016485724mm, y_size=0.095676415mm)
  Bottom_gnd.subtract(Rectangle25)
  Rectangle26 = rectangle(corner=(0.0008mm, -0.123mm, 0mm), x_size=-0.0308mm, y_size=0.113mm)
  Bottom_gnd.subtract(Rectangle26)
  Rectangle27 = rectangle(corner=(-0.21mm, -0.05mm, 0mm), x_size=0.21mm, y_size=0.04mm)
  Rectangle28 = rectangle(corner=(-0.21mm, -0.05mm, 0mm), x_size=0.03mm, y_size=-0.07mm)
  Rectangle29 = rectangle(corner=(-0.21164857mm, -0.11217641mm, 0mm), x_size=0.0016485724mm, y_size=0.095676415mm)
  Rectangle30 = rectangle(corner=(0.0008mm, -0.123mm, 0mm), x_size=-0.0308mm, y_size=0.113mm)
  Bottom_gnd.unite(Rectangle27..Rectangle30)
  cut_resonator15 = polyline((-0.0004-$s-$W/2, -0.0010+25um-$gap, 0) (-0.0004+$s+$W/2, -0.001+25um-$gap, 0))
  cut_resonator_path15 = polyline(z=0, xy: (-0.0004, -0.001+25um-$gap) (-0.0004, -0.0006+25um-$gap) (-0.00017820834, -0.0006+25um-$gap) (-0.00017820834, -0.0004+25um-$gap) (-0.00062179166, -0.0004+25um-$gap) (-0.00062179166, -0.0002+25um-$gap) (-0.00017820834, -0.0002+25um-$gap) (-0.00017820834, -0.0000+25um-$gap) (-0.00062179166, -0.0000+25um-$gap) (-0.00062179166, 0.0002+25um-$gap) (-0.00017820834, 0.0002+25um-$gap) (-0.00017820834, 0.0004+25um-$gap) (-0.00039, 0.0004+25um-$gap) (-0.00039, 0.000774+25um-$gap) (0.0004, 0.000774+25um-$gap) (0.0004, 0.00020512+25um-$gap-$delta_length))
  cut_resonator_path15.fillet(Vertices=cut_resonator_path15.vertex(at (-0.4, -0.6, 0), at (-0.178208, -0.6, 0), at (-0.178208, -0.4, 0), at (-0.621792, -0.4, 0), at (-0.621792, -0.2, 0), at (-0.178208, -0.2, 0), at (-0.178208, 0, 0), at (-0.621792, 0, 0), at (-0.621792, 0.2, 0), at (-0.178208, 0.2, 0), at (-0.178208, 0.4, 0), at (-0.39, 0.4, 0)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) Radius=9e-05 Setback=0mm)
  cut_resonator15.sweep_along_path(cut_resonator_path15)
  cut_resonator15.move(0mm, -0.02mm, 0mm)
  cut_resonator15.move(0mm, 0mm, 0mm)
  cut_resonator15.move(0mm, 0.013mm, 0mm)
  cut_resonator15.move(0mm, -0.78mm, 0mm)
  cut_resonator15.move(0mm, 0.01mm, 0mm)
  cut_resonator15.move(0mm, -0.04mm, 0mm)
  cut_resonator15.move(0mm, 0.01mm, 0mm)
  Rectangle31 = rectangle(corner=(0.31mm, -0.0165mm, 0mm), x_size=-0.4157mm, y_size=-0.033mm)
  Rectangle7_7 = Rectangle31.copy()
  cut_resonator15.subtract(Rectangle7_7)
  cut_resonator8_Separate6 = cut_resonator15.separate_bodies()
  cut_resonator8_Separate6.move(-0.4157mm, 0mm, 0mm)
  cut_resonator8_Separate6.unite(cut_resonator15)
  Rectangle32 = rectangle(corner=(-0.55mm, -0.5mm, 0mm), x_size=0.45mm, y_size=0.2mm)
  cut_resonator8_Separate6.subtract(Rectangle32)
  cut_resonator8_Separate3_Separate4 = cut_resonator8_Separate6.separate_bodies()
  cut_resonator8_Separate3_Separate4.move(-0.211791663mm, 0.2mm, 0mm)
  cut_resonator8_Separate6.unite(cut_resonator8_Separate3_Separate4)
  Rectangle33 = rectangle(corner=(-0.3mm, -0.05mm, 0mm), x_size=0.1943mm, y_size=0.0335mm)
  Rectangle20_2 = Rectangle33.copy()
  cut_resonator8_Separate6.subtract(Rectangle20_2)
  cut_resonator8_Separate3_Separate3 = cut_resonator8_Separate6.separate_bodies()
  [Rectangle31, Rectangle33].delete()
  cut_resonator8_Separate3_Separate3.move(0.1943mm, -2.289835e-16mm, 0mm)
  cut_resonator8_Separate3_Separate3.unite(cut_resonator8_Separate6)
  Bottom_gnd.subtract(cut_resonator8_Separate3_Separate3)
  Rectangle34 = rectangle(corner=(-0.21mm, -0.01mm, 0mm), x_size=0.2108mm, y_size=-0.0065mm)
  Bottom_gnd.subtract(Rectangle34)
  Rectangle35 = rectangle(corner=(-0.433991663mm, -1.607mm, 0mm), x_size=0.032991663mm, y_size=0.261mm)
  Rectangle36 = rectangle(corner=(-0.433991663mm, -1.607mm, 0mm), x_size=0.032991663mm, y_size=0.261mm)
  Bottom_gnd.unite(Rectangle35)
  trace_resonator1_Separate1.subtract(Rectangle36)
  Rectangle37 = rectangle(corner=(-0.433991663mm, -1.607mm, 0mm), x_size=0.032991663mm, y_size=0.261mm)
  Bottom_gnd.subtract(Rectangle37)
  Rectangle38 = rectangle(corner=(-0.424991663mm, -1.346mm, 0mm), x_size=0.015mm, y_size=-0.261mm)
  trace_resonator1_Separate1.unite(Rectangle38)
  Rectangle39 = rectangle(corner=(-0.145mm, -0.025mm, 0mm), x_size=0.085mm, y_size=0.01mm)
  Bottom_gnd.subtract(Rectangle39)
  Rectangle40 = rectangle(corner=(-0.06mm, -0.025mm, 0mm), x_size=-0.005mm, y_size=-0.005mm)
  Bottom_gnd.subtract(Rectangle40)
  cut_resonator16 = polyline((-0.0004-$s-$W/2, -0.0010+25um-$gap, 0) (-0.0004+$s+$W/2, -0.001+25um-$gap, 0))
  cut_resonator_path16 = polyline(z=0, xy: (-0.0004, -0.001+25um-$gap) (-0.0004, -0.0006+25um-$gap) (-0.00017820834, -0.0006+25um-$gap) (-0.00017820834, -0.0004+25um-$gap) (-0.00062179166, -0.0004+25um-$gap) (-0.00062179166, -0.0002+25um-$gap) (-0.00017820834, -0.0002+25um-$gap) (-0.00017820834, -0.0000+25um-$gap) (-0.00062179166, -0.0000+25um-$gap) (-0.00062179166, 0.0002+25um-$gap) (-0.00017820834, 0.0002+25um-$gap) (-0.00017820834, 0.0004+25um-$gap) (-0.00039, 0.0004+25um-$gap) (-0.00039, 0.000774+25um-$gap) (0.0004, 0.000774+25um-$gap) (0.0004, 0.00020512+25um-$gap-$delta_length))
  cut_resonator_path16.fillet(Vertices=cut_resonator_path16.vertex(at (-0.4, -0.6, 0), at (-0.178208, -0.6, 0), at (-0.178208, -0.4, 0), at (-0.621792, -0.4, 0), at (-0.621792, -0.2, 0), at (-0.178208, -0.2, 0), at (-0.178208, 0, 0), at (-0.621792, 0, 0), at (-0.621792, 0.2, 0), at (-0.178208, 0.2, 0), at (-0.178208, 0.4, 0), at (-0.39, 0.4, 0)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) Radius=9e-05 Setback=0mm)
  cut_resonator16.sweep_along_path(cut_resonator_path16)
  cut_resonator16.move(0mm, -0.02mm, 0mm)
  cut_resonator16.move(0mm, 0mm, 0mm)
  cut_resonator16.move(0mm, 0.013mm, 0mm)
  cut_resonator16.move(0mm, -0.78mm, 0mm)
  cut_resonator16.move(0mm, 0.01mm, 0mm)
  cut_resonator16.move(0mm, -0.04mm, 0mm)
  cut_resonator16.move(0mm, 0.01mm, 0mm)
  Rectangle41 = rectangle(corner=(0.31mm, -0.0165mm, 0mm), x_size=-0.4157mm, y_size=-0.033mm)
  Rectangle7_8 = Rectangle41.copy()
  cut_resonator16.subtract(Rectangle7_8)
  cut_resonator8_Separate7 = cut_resonator16.separate_bodies()
  cut_resonator8_Separate7.move(-0.4157mm, 0mm, 0mm)
  cut_resonator8_Separate7.unite(cut_resonator16)
  Rectangle42 = rectangle(corner=(-0.55mm, -0.5mm, 0mm), x_size=0.45mm, y_size=0.2mm)
  cut_resonator8_Separate7.subtract(Rectangle42)
  cut_resonator8_Separate3_Separate6 = cut_resonator8_Separate7.separate_bodies()
  cut_resonator8_Separate3_Separate6.move(-0.211791663mm, 0.2mm, 0mm)
  cut_resonator8_Separate7.unite(cut_resonator8_Separate3_Separate6)
  Rectangle43 = rectangle(corner=(-0.3mm, -0.05mm, 0mm), x_size=0.1943mm, y_size=0.0335mm)
  Rectangle20_3 = Rectangle43.copy()
  cut_resonator8_Separate7.subtract(Rectangle20_3)
  cut_resonator8_Separate3_Separate5 = cut_resonator8_Separate7.separate_bodies()
  [Rectangle41, Rectangle43].delete()
  cut_resonator8_Separate3_Separate5.move(0.1943mm, -2.289835e-16mm, 0mm)
  cut_resonator8_Separate3_Separate5.unite(cut_resonator8_Separate7)
  cut_resonator17 = polyline((-0.0004-$s-$W/2, -0.0010+25um-$gap, 0) (-0.0004+$s+$W/2, -0.001+25um-$gap, 0))
  cut_resonator_path17 = polyline(z=0, xy: (-0.0004, -0.001+25um-$gap) (-0.0004, -0.0006+25um-$gap) (-0.00017820834, -0.0006+25um-$gap) (-0.00017820834, -0.0004+25um-$gap) (-0.00062179166, -0.0004+25um-$gap) (-0.00062179166, -0.0002+25um-$gap) (-0.00017820834, -0.0002+25um-$gap) (-0.00017820834, -0.0000+25um-$gap) (-0.00062179166, -0.0000+25um-$gap) (-0.00062179166, 0.0002+25um-$gap) (-0.00017820834, 0.0002+25um-$gap) (-0.00017820834, 0.0004+25um-$gap) (-0.00039, 0.0004+25um-$gap) (-0.00039, 0.000774+25um-$gap) (0.0004, 0.000774+25um-$gap) (0.0004, 0.00020512+25um-$gap-$delta_length))
  cut_resonator_path17.fillet(Vertices=cut_resonator_path17.vertex(at (-0.4, -0.6, 0), at (-0.178208, -0.6, 0), at (-0.178208, -0.4, 0), at (-0.621792, -0.4, 0), at (-0.621792, -0.2, 0), at (-0.178208, -0.2, 0), at (-0.178208, 0, 0), at (-0.621792, 0, 0), at (-0.621792, 0.2, 0), at (-0.178208, 0.2, 0), at (-0.178208, 0.4, 0), at (-0.39, 0.4, 0)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) Radius=9e-05 Setback=0mm)
  cut_resonator17.sweep_along_path(cut_resonator_path17)
  cut_resonator17.move(0mm, -0.02mm, 0mm)
  cut_resonator17.move(0mm, 0mm, 0mm)
  cut_resonator17.move(0mm, 0.013mm, 0mm)
  cut_resonator17.move(0mm, -0.78mm, 0mm)
  cut_resonator17.move(0mm, 0.01mm, 0mm)
  cut_resonator17.move(0mm, -0.04mm, 0mm)
  cut_resonator17.move(0mm, 0.01mm, 0mm)
  Rectangle44 = rectangle(corner=(0.31mm, -0.0165mm, 0mm), x_size=-0.4157mm, y_size=-0.033mm)
  Rectangle7_9 = Rectangle44.copy()
  cut_resonator17.subtract(Rectangle7_9)
  cut_resonator8_Separate8 = cut_resonator17.separate_bodies()
  cut_resonator8_Separate8.move(-0.4157mm, 0mm, 0mm)
  cut_resonator8_Separate8.unite(cut_resonator17)
  Rectangle45 = rectangle(corner=(-0.55mm, -0.5mm, 0mm), x_size=0.45mm, y_size=0.2mm)
  cut_resonator8_Separate8.subtract(Rectangle45)
  cut_resonator8_Separate3_Separate8 = cut_resonator8_Separate8.separate_bodies()
  cut_resonator8_Separate3_Separate8.move(-0.211791663mm, 0.2mm, 0mm)
  cut_resonator8_Separate8.unite(cut_resonator8_Separate3_Separate8)
  Rectangle46 = rectangle(corner=(-0.3mm, -0.05mm, 0mm), x_size=0.1943mm, y_size=0.0335mm)
  Rectangle20_4 = Rectangle46.copy()
  cut_resonator8_Separate8.subtract(Rectangle20_4)
  cut_resonator8_Separate3_Separate7 = cut_resonator8_Separate8.separate_bodies()
  [Rectangle44, Rectangle46].delete()
  cut_resonator8_Separate3_Separate7.move(0.1943mm, -2.289835e-16mm, 0mm)
  cut_resonator8_Separate3_Separate7.unite(cut_resonator8_Separate8)
  Bottom_gnd.unite(cut_resonator8_Separate3_Separate5)
  cut_resonator8_Separate3_Separate7.move(-2.7755576e-17mm, -0.015mm, 0mm)
  trace_resonator1_Separate1.move(0mm, -0.015mm, 0mm)
  Bottom_gnd.subtract(cut_resonator8_Separate3_Separate7)
  Rectangle47 = rectangle(corner=(-0.145mm, -0.0165mm, 0mm), x_size=0.085mm, y_size=-0.0285mm)
  Bottom_gnd.subtract(Rectangle47)
  Rectangle48 = rectangle(corner=(-0.145mm, -0.0165mm, 0mm), x_size=0.085mm, y_size=-0.012651767mm)
  Bottom_gnd.unite(Rectangle48)
  Rectangle49 = rectangle(corner=(-0.145mm, -0.0165mm, 0mm), x_size=0.085mm, y_size=-0.012651767mm)
  Bottom_gnd.subtract(Rectangle49)
  cut_resonator18 = polyline((-0.0004-$s-$W/2, -0.0010+25um-$gap, 0) (-0.0004+$s+$W/2, -0.001+25um-$gap, 0))
  cut_resonator_path18 = polyline(z=0, xy: (-0.0004, -0.001+25um-$gap) (-0.0004, -0.0006+25um-$gap) (-0.00017820834, -0.0006+25um-$gap) (-0.00017820834, -0.0004+25um-$gap) (-0.00062179166, -0.0004+25um-$gap) (-0.00062179166, -0.0002+25um-$gap) (-0.00017820834, -0.0002+25um-$gap) (-0.00017820834, -0.0000+25um-$gap) (-0.00062179166, -0.0000+25um-$gap) (-0.00062179166, 0.0002+25um-$gap) (-0.00017820834, 0.0002+25um-$gap) (-0.00017820834, 0.0004+25um-$gap) (-0.00039, 0.0004+25um-$gap) (-0.00039, 0.000774+25um-$gap) (0.0004, 0.000774+25um-$gap) (0.0004, 0.00020512+25um-$gap-$delta_length))
  cut_resonator_path18.fillet(Vertices=cut_resonator_path18.vertex(at (-0.4, -0.6, 0), at (-0.178208, -0.6, 0), at (-0.178208, -0.4, 0), at (-0.621792, -0.4, 0), at (-0.621792, -0.2, 0), at (-0.178208, -0.2, 0), at (-0.178208, 0, 0), at (-0.621792, 0, 0), at (-0.621792, 0.2, 0), at (-0.178208, 0.2, 0), at (-0.178208, 0.4, 0), at (-0.39, 0.4, 0)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) Radius=9e-05 Setback=0mm)
  cut_resonator18.sweep_along_path(cut_resonator_path18)
  cut_resonator18.move(0mm, -0.02mm, 0mm)
  cut_resonator18.move(0mm, 0mm, 0mm)
  cut_resonator18.move(0mm, 0.013mm, 0mm)
  cut_resonator18.move(0mm, -0.78mm, 0mm)
  cut_resonator18.move(0mm, 0.01mm, 0mm)
  cut_resonator18.move(0mm, -0.04mm, 0mm)
  cut_resonator18.move(0mm, 0.01mm, 0mm)
  Rectangle50 = rectangle(corner=(0.31mm, -0.0165mm, 0mm), x_size=-0.4157mm, y_size=-0.033mm)
  Rectangle7_10 = Rectangle50.copy()
  cut_resonator18.subtract(Rectangle7_10)
  cut_resonator8_Separate9 = cut_resonator18.separate_bodies()
  cut_resonator8_Separate9.move(-0.4157mm, 0mm, 0mm)
  cut_resonator8_Separate9.unite(cut_resonator18)
  Rectangle51 = rectangle(corner=(-0.55mm, -0.5mm, 0mm), x_size=0.45mm, y_size=0.2mm)
  cut_resonator8_Separate9.subtract(Rectangle51)
  cut_resonator8_Separate3_Separate10 = cut_resonator8_Separate9.separate_bodies()
  cut_resonator8_Separate3_Separate10.move(-0.211791663mm, 0.2mm, 0mm)
  cut_resonator8_Separate9.unite(cut_resonator8_Separate3_Separate10)
  Rectangle52 = rectangle(corner=(-0.3mm, -0.05mm, 0mm), x_size=0.1943mm, y_size=0.0335mm)
  Rectangle20_5 = Rectangle52.copy()
  cut_resonator8_Separate9.subtract(Rectangle20_5)
  cut_resonator8_Separate3_Separate9 = cut_resonator8_Separate9.separate_bodies()
  [Rectangle50, Rectangle52].delete()
  cut_resonator8_Separate3_Separate9.move(0.1943mm, -2.289835e-16mm, 0mm)
  cut_resonator8_Separate3_Separate9.unite(cut_resonator8_Separate9)
  cut_resonator8_Separate3_Separate9.move(-2.7755576e-17mm, -0.015mm, 0mm)
  cut_resonator8_Separate3_Separate9.move(-0.0003mm, 0.0145mm, 0mm)
  cut_resonator19 = polyline((-0.0004-$s-$W/2, -0.0010+25um-$gap, 0) (-0.0004+$s+$W/2, -0.001+25um-$gap, 0))
  cut_resonator_path19 = polyline(z=0, xy: (-0.0004, -0.001+25um-$gap) (-0.0004, -0.0006+25um-$gap) (-0.00017820834, -0.0006+25um-$gap) (-0.00017820834, -0.0004+25um-$gap) (-0.00062179166, -0.0004+25um-$gap) (-0.00062179166, -0.0002+25um-$gap) (-0.00017820834, -0.0002+25um-$gap) (-0.00017820834, -0.0000+25um-$gap) (-0.00062179166, -0.0000+25um-$gap) (-0.00062179166, 0.0002+25um-$gap) (-0.00017820834, 0.0002+25um-$gap) (-0.00017820834, 0.0004+25um-$gap) (-0.00039, 0.0004+25um-$gap) (-0.00039, 0.000774+25um-$gap) (0.0004, 0.000774+25um-$gap) (0.0004, 0.00020512+25um-$gap-$delta_length))
  cut_resonator_path19.fillet(Vertices=cut_resonator_path19.vertex(at (-0.4, -0.6, 0), at (-0.178208, -0.6, 0), at (-0.178208, -0.4, 0), at (-0.621792, -0.4, 0), at (-0.621792, -0.2, 0), at (-0.178208, -0.2, 0), at (-0.178208, 0, 0), at (-0.621792, 0, 0), at (-0.621792, 0.2, 0), at (-0.178208, 0.2, 0), at (-0.178208, 0.4, 0), at (-0.39, 0.4, 0)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) Radius=9e-05 Setback=0mm)
  cut_resonator19.sweep_along_path(cut_resonator_path19)
  cut_resonator19.move(0mm, -0.02mm, 0mm)
  cut_resonator19.move(0mm, 0mm, 0mm)
  cut_resonator19.move(0mm, 0.013mm, 0mm)
  cut_resonator19.move(0mm, -0.78mm, 0mm)
  cut_resonator19.move(0mm, 0.01mm, 0mm)
  cut_resonator19.move(0mm, -0.04mm, 0mm)
  cut_resonator19.move(0mm, 0.01mm, 0mm)
  Rectangle53 = rectangle(corner=(0.31mm, -0.0165mm, 0mm), x_size=-0.4157mm, y_size=-0.033mm)
  Rectangle7_11 = Rectangle53.copy()
  cut_resonator19.subtract(Rectangle7_11)
  cut_resonator8_Separate10 = cut_resonator19.separate_bodies()
  cut_resonator8_Separate10.move(-0.4157mm, 0mm, 0mm)
  cut_resonator8_Separate10.unite(cut_resonator19)
  Rectangle54 = rectangle(corner=(-0.55mm, -0.5mm, 0mm), x_size=0.45mm, y_size=0.2mm)
  cut_resonator8_Separate10.subtract(Rectangle54)
  cut_resonator8_Separate3_Separate12 = cut_resonator8_Separate10.separate_bodies()
  cut_resonator8_Separate3_Separate12.move(-0.211791663mm, 0.2mm, 0mm)
  cut_resonator8_Separate10.unite(cut_resonator8_Separate3_Separate12)
  Rectangle55 = rectangle(corner=(-0.3mm, -0.05mm, 0mm), x_size=0.1943mm, y_size=0.0335mm)
  Rectangle20_6 = Rectangle55.copy()
  cut_resonator8_Separate10.subtract(Rectangle20_6)
  cut_resonator8_Separate3_Separate11 = cut_resonator8_Separate10.separate_bodies()
  [Rectangle53, Rectangle55].delete()
  cut_resonator8_Separate3_Separate11.move(0.1943mm, -2.289835e-16mm, 0mm)
  cut_resonator8_Separate3_Separate11.unite(cut_resonator8_Separate10)
  cut_resonator8_Separate3_Separate11.move(-2.7755576e-17mm, -0.015mm, 0mm)
  Bottom_gnd.unite(cut_resonator8_Separate3_Separate11)
  trace_resonator1_Separate1.move(-0.0003mm, 0.0145mm, 0mm)
  Bottom_gnd.subtract(cut_resonator8_Separate3_Separate9)
  cut_resonator20 = polyline((-0.0004-$s-$W/2, -0.0010+25um-$gap, 0) (-0.0004+$s+$W/2, -0.001+25um-$gap, 0))
  cut_resonator_path20 = polyline(z=0, xy: (-0.0004, -0.001+25um-$gap) (-0.0004, -0.0006+25um-$gap) (-0.00017820834, -0.0006+25um-$gap) (-0.00017820834, -0.0004+25um-$gap) (-0.00062179166, -0.0004+25um-$gap) (-0.00062179166, -0.0002+25um-$gap) (-0.00017820834, -0.0002+25um-$gap) (-0.00017820834, -0.0000+25um-$gap) (-0.00062179166, -0.0000+25um-$gap) (-0.00062179166, 0.0002+25um-$gap) (-0.00017820834, 0.0002+25um-$gap) (-0.00017820834, 0.0004+25um-$gap) (-0.00039, 0.0004+25um-$gap) (-0.00039, 0.000774+25um-$gap) (0.0004, 0.000774+25um-$gap) (0.0004, 0.00020512+25um-$gap-$delta_length))
  cut_resonator_path20.fillet(Vertices=cut_resonator_path20.vertex(at (-0.4, -0.6, 0), at (-0.178208, -0.6, 0), at (-0.178208, -0.4, 0), at (-0.621792, -0.4, 0), at (-0.621792, -0.2, 0), at (-0.178208, -0.2, 0), at (-0.178208, 0, 0), at (-0.621792, 0, 0), at (-0.621792, 0.2, 0), at (-0.178208, 0.2, 0), at (-0.178208, 0.4, 0), at (-0.39, 0.4, 0)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) Radius=9e-05 Setback=0mm)
  cut_resonator20.sweep_along_path(cut_resonator_path20)
  cut_resonator20.move(0mm, -0.02mm, 0mm)
  cut_resonator20.move(0mm, 0mm, 0mm)
  cut_resonator20.move(0mm, 0.013mm, 0mm)
  cut_resonator20.move(0mm, -0.78mm, 0mm)
  cut_resonator20.move(0mm, 0.01mm, 0mm)
  cut_resonator20.move(0mm, -0.04mm, 0mm)
  cut_resonator20.move(0mm, 0.01mm, 0mm)
  Rectangle56 = rectangle(corner=(0.31mm, -0.0165mm, 0mm), x_size=-0.4157mm, y_size=-0.033mm)
  Rectangle7_12 = Rectangle56.copy()
  cut_resonator20.subtract(Rectangle7_12)
  cut_resonator8_Separate11 = cut_resonator20.separate_bodies()
  cut_resonator8_Separate11.move(-0.4157mm, 0mm, 0mm)
  cut_resonator8_Separate11.unite(cut_resonator20)
  Rectangle57 = rectangle(corner=(-0.55mm, -0.5mm, 0mm), x_size=0.45mm, y_size=0.2mm)
  cut_resonator8_Separate11.subtract(Rectangle57)
  cut_resonator8_Separate3_Separate14 = cut_resonator8_Separate11.separate_bodies()
  cut_resonator8_Separate3_Separate14.move(-0.211791663mm, 0.2mm, 0mm)
  cut_resonator8_Separate11.unite(cut_resonator8_Separate3_Separate14)
  Rectangle58 = rectangle(corner=(-0.3mm, -0.05mm, 0mm), x_size=0.1943mm, y_size=0.0335mm)
  Rectangle20_7 = Rectangle58.copy()
  cut_resonator8_Separate11.subtract(Rectangle20_7)
  cut_resonator8_Separate3_Separate13 = cut_resonator8_Separate11.separate_bodies()
  [Rectangle56, Rectangle58].delete()
  cut_resonator8_Separate3_Separate13.move(0.1943mm, -2.289835e-16mm, 0mm)
  cut_resonator8_Separate3_Separate13.unite(cut_resonator8_Separate11)
  cut_resonator8_Separate3_Separate13.move(-2.7755576e-17mm, -0.015mm, 0mm)
  cut_resonator8_Separate3_Separate13.move(-0.0003mm, 0.0145mm, 0mm)
  Rectangle59 = rectangle(corner=(-0.145mm, -0.0165mm, 0mm), x_size=0.085mm, y_size=-0.0082099721mm)
  Bottom_gnd.unite(Rectangle59)
  Bottom_gnd.subtract(cut_resonator8_Separate3_Separate13)
  Rectangle60 = rectangle(corner=(-0.06mm, -0.025mm, 0mm), x_size=-0.08mm, y_size=0.01mm)
  Bottom_gnd.subtract(Rectangle60)
  cut_resonator21 = polyline((-0.0004-$s-$W/2, -0.0010+25um-$gap, 0) (-0.0004+$s+$W/2, -0.001+25um-$gap, 0))
  cut_resonator_path21 = polyline(z=0, xy: (-0.0004, -0.001+25um-$gap) (-0.0004, -0.0006+25um-$gap) (-0.00017820834, -0.0006+25um-$gap) (-0.00017820834, -0.0004+25um-$gap) (-0.00062179166, -0.0004+25um-$gap) (-0.00062179166, -0.0002+25um-$gap) (-0.00017820834, -0.0002+25um-$gap) (-0.00017820834, -0.0000+25um-$gap) (-0.00062179166, -0.0000+25um-$gap) (-0.00062179166, 0.0002+25um-$gap) (-0.00017820834, 0.0002+25um-$gap) (-0.00017820834, 0.0004+25um-$gap) (-0.00039, 0.0004+25um-$gap) (-0.00039, 0.000774+25um-$gap) (0.0004, 0.000774+25um-$gap) (0.0004, 0.00020512+25um-$gap-$delta_length))
  cut_resonator_path21.fillet(Vertices=cut_resonator_path21.vertex(at (-0.4, -0.6, 0), at (-0.178208, -0.6, 0), at (-0.178208, -0.4, 0), at (-0.621792, -0.4, 0), at (-0.621792, -0.2, 0), at (-0.178208, -0.2, 0), at (-0.178208, 0, 0), at (-0.621792, 0, 0), at (-0.621792, 0.2, 0), at (-0.178208, 0.2, 0), at (-0.178208, 0.4, 0), at (-0.39, 0.4, 0)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) Radius=9e-05 Setback=0mm)
  cut_resonator21.sweep_along_path(cut_resonator_path21)
  cut_resonator21.move(0mm, -0.02mm, 0mm)
  cut_resonator21.move(0mm, 0mm, 0mm)
  cut_resonator21.move(0mm, 0.013mm, 0mm)
  cut_resonator21.move(0mm, -0.78mm, 0mm)
  cut_resonator21.move(0mm, 0.01mm, 0mm)
  cut_resonator21.move(0mm, -0.04mm, 0mm)
  cut_resonator21.move(0mm, 0.01mm, 0mm)
  Rectangle61 = rectangle(corner=(0.31mm, -0.0165mm, 0mm), x_size=-0.4157mm, y_size=-0.033mm)
  Rectangle7_13 = Rectangle61.copy()
  cut_resonator21.subtract(Rectangle7_13)
  cut_resonator8_Separate12 = cut_resonator21.separate_bodies()
  cut_resonator8_Separate12.move(-0.4157mm, 0mm, 0mm)
  cut_resonator8_Separate12.unite(cut_resonator21)
  Rectangle62 = rectangle(corner=(-0.55mm, -0.5mm, 0mm), x_size=0.45mm, y_size=0.2mm)
  cut_resonator8_Separate12.subtract(Rectangle62)
  cut_resonator8_Separate3_Separate16 = cut_resonator8_Separate12.separate_bodies()
  cut_resonator8_Separate3_Separate16.move(-0.211791663mm, 0.2mm, 0mm)
  cut_resonator8_Separate12.unite(cut_resonator8_Separate3_Separate16)
  Rectangle63 = rectangle(corner=(-0.3mm, -0.05mm, 0mm), x_size=0.1943mm, y_size=0.0335mm)
  Rectangle20_8 = Rectangle63.copy()
  cut_resonator8_Separate12.subtract(Rectangle20_8)
  cut_resonator8_Separate3_Separate15 = cut_resonator8_Separate12.separate_bodies()
  [Rectangle61, Rectangle63].delete()
  cut_resonator8_Separate3_Separate15.move(0.1943mm, -2.289835e-16mm, 0mm)
  cut_resonator8_Separate3_Separate15.unite(cut_resonator8_Separate12)
  cut_resonator8_Separate3_Separate15.move(-2.7755576e-17mm, -0.015mm, 0mm)
  cut_resonator8_Separate3_Separate15.move(-0.0003mm, 0.0145mm, 0mm)
  cut_resonator22 = polyline((-0.0004-$s-$W/2, -0.0010+25um-$gap, 0) (-0.0004+$s+$W/2, -0.001+25um-$gap, 0))
  cut_resonator_path22 = polyline(z=0, xy: (-0.0004, -0.001+25um-$gap) (-0.0004, -0.0006+25um-$gap) (-0.00017820834, -0.0006+25um-$gap) (-0.00017820834, -0.0004+25um-$gap) (-0.00062179166, -0.0004+25um-$gap) (-0.00062179166, -0.0002+25um-$gap) (-0.00017820834, -0.0002+25um-$gap) (-0.00017820834, -0.0000+25um-$gap) (-0.00062179166, -0.0000+25um-$gap) (-0.00062179166, 0.0002+25um-$gap) (-0.00017820834, 0.0002+25um-$gap) (-0.00017820834, 0.0004+25um-$gap) (-0.00039, 0.0004+25um-$gap) (-0.00039, 0.000774+25um-$gap) (0.0004, 0.000774+25um-$gap) (0.0004, 0.00020512+25um-$gap-$delta_length))
  cut_resonator_path22.fillet(Vertices=cut_resonator_path22.vertex(at (-0.4, -0.6, 0), at (-0.178208, -0.6, 0), at (-0.178208, -0.4, 0), at (-0.621792, -0.4, 0), at (-0.621792, -0.2, 0), at (-0.178208, -0.2, 0), at (-0.178208, 0, 0), at (-0.621792, 0, 0), at (-0.621792, 0.2, 0), at (-0.178208, 0.2, 0), at (-0.178208, 0.4, 0), at (-0.39, 0.4, 0)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) Radius=9e-05 Setback=0mm)
  cut_resonator22.sweep_along_path(cut_resonator_path22)
  cut_resonator22.move(0mm, -0.02mm, 0mm)
  cut_resonator22.move(0mm, 0mm, 0mm)
  cut_resonator22.move(0mm, 0.013mm, 0mm)
  cut_resonator22.move(0mm, -0.78mm, 0mm)
  cut_resonator22.move(0mm, 0.01mm, 0mm)
  cut_resonator22.move(0mm, -0.04mm, 0mm)
  cut_resonator22.move(0mm, 0.01mm, 0mm)
  Rectangle64 = rectangle(corner=(0.31mm, -0.0165mm, 0mm), x_size=-0.4157mm, y_size=-0.033mm)
  Rectangle7_14 = Rectangle64.copy()
  cut_resonator22.subtract(Rectangle7_14)
  cut_resonator8_Separate13 = cut_resonator22.separate_bodies()
  cut_resonator8_Separate13.move(-0.4157mm, 0mm, 0mm)
  cut_resonator8_Separate13.unite(cut_resonator22)
  Rectangle65 = rectangle(corner=(-0.55mm, -0.5mm, 0mm), x_size=0.45mm, y_size=0.2mm)
  cut_resonator8_Separate13.subtract(Rectangle65)
  cut_resonator8_Separate3_Separate18 = cut_resonator8_Separate13.separate_bodies()
  cut_resonator8_Separate3_Separate18.move(-0.211791663mm, 0.2mm, 0mm)
  cut_resonator8_Separate13.unite(cut_resonator8_Separate3_Separate18)
  Rectangle66 = rectangle(corner=(-0.3mm, -0.05mm, 0mm), x_size=0.1943mm, y_size=0.0335mm)
  Rectangle20_9 = Rectangle66.copy()
  cut_resonator8_Separate13.subtract(Rectangle20_9)
  cut_resonator8_Separate3_Separate17 = cut_resonator8_Separate13.separate_bodies()
  [Rectangle64, Rectangle66].delete()
  cut_resonator8_Separate3_Separate17.move(0.1943mm, -2.289835e-16mm, 0mm)
  cut_resonator8_Separate3_Separate17.unite(cut_resonator8_Separate13)
  cut_resonator8_Separate3_Separate17.move(-2.7755576e-17mm, -0.015mm, 0mm)
  cut_resonator8_Separate3_Separate17.move(-0.0003mm, 0.0145mm, 0mm)
  Bottom_gnd.unite(cut_resonator8_Separate3_Separate15)
  Rectangle67 = rectangle(corner=(-0.118mm, -0.016mm, 0mm), x_size=0.034mm, y_size=-0.042mm)
  Rectangle67_1 = Rectangle67.copy()
  cut_resonator8_Separate3_Separate17.subtract(Rectangle67_1)
  trace_resonator1_Separate1.subtract(Rectangle67)
  cut_resonator8_Separate3_Separate17_Separate1 = cut_resonator8_Separate3_Separate17.separate_bodies()
  cut_resonator8_Separate3_Separate17_Separate1.move(0.034mm, -0.0020240823mm, 0mm)
  trace_resonator1_Separate1_Separate1 = trace_resonator1_Separate1.separate_bodies()
  trace_resonator1_Separate1_Separate1.move(0.034mm, -0.0020469582mm, 0mm)
  cut_resonator8_Separate3_Separate17_Separate1.unite(cut_resonator8_Separate3_Separate17)
  trace_resonator1_Separate1.unite(trace_resonator1_Separate1_Separate1)
  Bottom_gnd.subtract(cut_resonator8_Separate3_Separate17_Separate1)
  Rectangle68 = rectangle(corner=(-0.14mm, -0.0165mm, 0mm), x_size=0.056mm, y_size=-0.0075mm)
  Bottom_gnd.unite(Rectangle68)
  cut_resonator23 = polyline((-0.0004-$s-$W/2, -0.0010+25um-$gap, 0) (-0.0004+$s+$W/2, -0.001+25um-$gap, 0))
  cut_resonator_path23 = polyline(z=0, xy: (-0.0004, -0.001+25um-$gap) (-0.0004, -0.0006+25um-$gap) (-0.00017820834, -0.0006+25um-$gap) (-0.00017820834, -0.0004+25um-$gap) (-0.00062179166, -0.0004+25um-$gap) (-0.00062179166, -0.0002+25um-$gap) (-0.00017820834, -0.0002+25um-$gap) (-0.00017820834, -0.0000+25um-$gap) (-0.00062179166, -0.0000+25um-$gap) (-0.00062179166, 0.0002+25um-$gap) (-0.00017820834, 0.0002+25um-$gap) (-0.00017820834, 0.0004+25um-$gap) (-0.00039, 0.0004+25um-$gap) (-0.00039, 0.000774+25um-$gap) (0.0004, 0.000774+25um-$gap) (0.0004, 0.00020512+25um-$gap-$delta_length))
  cut_resonator_path23.fillet(Vertices=cut_resonator_path23.vertex(at (-0.4, -0.6, 0), at (-0.178208, -0.6, 0), at (-0.178208, -0.4, 0), at (-0.621792, -0.4, 0), at (-0.621792, -0.2, 0), at (-0.178208, -0.2, 0), at (-0.178208, 0, 0), at (-0.621792, 0, 0), at (-0.621792, 0.2, 0), at (-0.178208, 0.2, 0), at (-0.178208, 0.4, 0), at (-0.39, 0.4, 0)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) Radius=9e-05 Setback=0mm)
  cut_resonator23.sweep_along_path(cut_resonator_path23)
  cut_resonator23.move(0mm, -0.02mm, 0mm)
  cut_resonator23.move(0mm, 0mm, 0mm)
  cut_resonator23.move(0mm, 0.013mm, 0mm)
  cut_resonator23.move(0mm, -0.78mm, 0mm)
  cut_resonator23.move(0mm, 0.01mm, 0mm)
  cut_resonator23.move(0mm, -0.04mm, 0mm)
  cut_resonator23.move(0mm, 0.01mm, 0mm)
  Rectangle69 = rectangle(corner=(0.31mm, -0.0165mm, 0mm), x_size=-0.4157mm, y_size=-0.033mm)
  Rectangle7_15 = Rectangle69.copy()
  cut_resonator23.subtract(Rectangle7_15)
  cut_resonator8_Separate14 = cut_resonator23.separate_bodies()
  cut_resonator8_Separate14.move(-0.4157mm, 0mm, 0mm)
  cut_resonator8_Separate14.unite(cut_resonator23)
  Rectangle70 = rectangle(corner=(-0.55mm, -0.5mm, 0mm), x_size=0.45mm, y_size=0.2mm)
  cut_resonator8_Separate14.subtract(Rectangle70)
  cut_resonator8_Separate3_Separate20 = cut_resonator8_Separate14.separate_bodies()
  cut_resonator8_Separate3_Separate20.move(-0.211791663mm, 0.2mm, 0mm)
  cut_resonator8_Separate14.unite(cut_resonator8_Separate3_Separate20)
  Rectangle71 = rectangle(corner=(-0.3mm, -0.05mm, 0mm), x_size=0.1943mm, y_size=0.0335mm)
  Rectangle20_10 = Rectangle71.copy()
  cut_resonator8_Separate14.subtract(Rectangle20_10)
  cut_resonator8_Separate3_Separate19 = cut_resonator8_Separate14.separate_bodies()
  cut_resonator8_Separate3_Separate19.move(0.1943mm, -2.289835e-16mm, 0mm)
  cut_resonator8_Separate3_Separate19.unite(cut_resonator8_Separate14)
  cut_resonator8_Separate3_Separate19.move(-2.7755576e-17mm, -0.015mm, 0mm)
  cut_resonator8_Separate3_Separate19.move(-0.0003mm, 0.0145mm, 0mm)
  Rectangle72 = rectangle(corner=(-0.118mm, -0.016mm, 0mm), x_size=0.034mm, y_size=-0.042mm)
  Rectangle67_2 = Rectangle72.copy()
  cut_resonator8_Separate3_Separate19.subtract(Rectangle67_2)
  cut_resonator8_Separate3_Separate17_Separate2 = cut_resonator8_Separate3_Separate19.separate_bodies()
  [Rectangle69, Rectangle71, Rectangle72].delete()
  cut_resonator8_Separate3_Separate17_Separate2.move(0.034mm, -0.0020240823mm, 0mm)
  cut_resonator8_Separate3_Separate17_Separate2.unite(cut_resonator8_Separate3_Separate19)
  cut_resonator24 = polyline((-0.0004-$s-$W/2, -0.0010+25um-$gap, 0) (-0.0004+$s+$W/2, -0.001+25um-$gap, 0))
  cut_resonator_path24 = polyline(z=0, xy: (-0.0004, -0.001+25um-$gap) (-0.0004, -0.0006+25um-$gap) (-0.00017820834, -0.0006+25um-$gap) (-0.00017820834, -0.0004+25um-$gap) (-0.00062179166, -0.0004+25um-$gap) (-0.00062179166, -0.0002+25um-$gap) (-0.00017820834, -0.0002+25um-$gap) (-0.00017820834, -0.0000+25um-$gap) (-0.00062179166, -0.0000+25um-$gap) (-0.00062179166, 0.0002+25um-$gap) (-0.00017820834, 0.0002+25um-$gap) (-0.00017820834, 0.0004+25um-$gap) (-0.00039, 0.0004+25um-$gap) (-0.00039, 0.000774+25um-$gap) (0.0004, 0.000774+25um-$gap) (0.0004, 0.00020512+25um-$gap-$delta_length))
  cut_resonator_path24.fillet(Vertices=cut_resonator_path24.vertex(at (-0.4, -0.6, 0), at (-0.178208, -0.6, 0), at (-0.178208, -0.4, 0), at (-0.621792, -0.4, 0), at (-0.621792, -0.2, 0), at (-0.178208, -0.2, 0), at (-0.178208, 0, 0), at (-0.621792, 0, 0), at (-0.621792, 0.2, 0), at (-0.178208, 0.2, 0), at (-0.178208, 0.4, 0), at (-0.39, 0.4, 0)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) Radius=9e-05 Setback=0mm)
  cut_resonator24.sweep_along_path(cut_resonator_path24)
  cut_resonator24.move(0mm, -0.02mm, 0mm)
  cut_resonator24.move(0mm, 0mm, 0mm)
  cut_resonator24.move(0mm, 0.013mm, 0mm)
  cut_resonator24.move(0mm, -0.78mm, 0mm)
  cut_resonator24.move(0mm, 0.01mm, 0mm)
  cut_resonator24.move(0mm, -0.04mm, 0mm)
  cut_resonator24.move(0mm, 0.01mm, 0mm)
  Rectangle73 = rectangle(corner=(0.31mm, -0.0165mm, 0mm), x_size=-0.4157mm, y_size=-0.033mm)
  Rectangle7_16 = Rectangle73.copy()
  cut_resonator24.subtract(Rectangle7_16)
  cut_resonator8_Separate15 = cut_resonator24.separate_bodies()
  cut_resonator8_Separate15.move(-0.4157mm, 0mm, 0mm)
  cut_resonator8_Separate15.unite(cut_resonator24)
  Rectangle74 = rectangle(corner=(-0.55mm, -0.5mm, 0mm), x_size=0.45mm, y_size=0.2mm)
  cut_resonator8_Separate15.subtract(Rectangle74)
  cut_resonator8_Separate3_Separate22 = cut_resonator8_Separate15.separate_bodies()
  cut_resonator8_Separate3_Separate22.move(-0.211791663mm, 0.2mm, 0mm)
  cut_resonator8_Separate15.unite(cut_resonator8_Separate3_Separate22)
  Rectangle75 = rectangle(corner=(-0.3mm, -0.05mm, 0mm), x_size=0.1943mm, y_size=0.0335mm)
  Rectangle20_11 = Rectangle75.copy()
  cut_resonator8_Separate15.subtract(Rectangle20_11)
  cut_resonator8_Separate3_Separate21 = cut_resonator8_Separate15.separate_bodies()
  cut_resonator8_Separate3_Separate21.move(0.1943mm, -2.289835e-16mm, 0mm)
  cut_resonator8_Separate3_Separate21.unite(cut_resonator8_Separate15)
  cut_resonator8_Separate3_Separate21.move(-2.7755576e-17mm, -0.015mm, 0mm)
  cut_resonator8_Separate3_Separate21.move(-0.0003mm, 0.0145mm, 0mm)
  Rectangle76 = rectangle(corner=(-0.118mm, -0.016mm, 0mm), x_size=0.034mm, y_size=-0.042mm)
  Rectangle67_3 = Rectangle76.copy()
  cut_resonator8_Separate3_Separate21.subtract(Rectangle67_3)
  cut_resonator8_Separate3_Separate17_Separate3 = cut_resonator8_Separate3_Separate21.separate_bodies()
  [Rectangle73, Rectangle75, Rectangle76].delete()
  cut_resonator8_Separate3_Separate17_Separate3.move(0.034mm, -0.0020240823mm, 0mm)
  cut_resonator8_Separate3_Separate17_Separate3.unite(cut_resonator8_Separate3_Separate21)
  Bottom_gnd.unite(cut_resonator8_Separate3_Separate17_Separate3)
  Rectangle77 = rectangle(corner=(-0.084mm, -0.0165mm, 0mm), x_size=0.024mm, y_size=-0.010946629mm)
  Bottom_gnd.unite(Rectangle77)
  Rectangle78 = rectangle(corner=(-0.084mm, -0.019297073mm, 0mm), x_size=-0.002mm, y_size=-0.034702927mm)
  Rectangle78_1 = Rectangle78.copy()
  cut_resonator8_Separate3_Separate17_Separate2.subtract(Rectangle78_1)
  trace_resonator1_Separate1.subtract(Rectangle78)
  trace_resonator1_Separate1_Separate2 = trace_resonator1_Separate1.separate_bodies()
  cut_resonator8_Separate3_Separate17_Separate2_Separate1 = cut_resonator8_Separate3_Separate17_Separate2.separate_bodies()
  cut_resonator8_Separate3_Separate17_Separate2_Separate1.move(0.256mm, -0.003340993mm, 0mm)
  trace_resonator1_Separate1_Separate2.move(0.256mm, -0.0034234629mm, 0mm)
  Rectangle79 = rectangle(corner=(-0.086mm, -0.01994828mm, 0mm), x_size=0.258mm, y_size=-0.036762477mm)
  cut_resonator8_Separate3_Separate17_Separate2.unite(cut_resonator8_Separate3_Separate17_Separate2_Separate1, Rectangle79)
  Rectangle80 = rectangle(corner=(-0.086mm, -0.029057321mm, 0mm), x_size=0.258mm, y_size=-0.018353564mm)
  trace_resonator1_Separate1.unite(Rectangle80, trace_resonator1_Separate1_Separate2)
  Bottom_gnd.subtract(cut_resonator8_Separate3_Separate17_Separate2)
boundaries and excitations:
  Rad1: Radiation Objects=Box3
  PerfE5: Perfect E Objects=Bottom_gnd
  PerfE6: Perfect E Objects=Rectangle3
  PerfE8: Perfect E Objects=Rectangle8
  PerfE9: Perfect E Objects=trace_resonator1_Separate1
  2: Wave Port Objects=Rectangle4 WavePortType=Modal NumModes=1 Modes{Mode1{IntLine{(-1, 0, 0) -> (-1, 0.0165, 0)} CharImp=Zpi RenormImp=50ohm}}
  1: Wave Port Objects=Rectangle5 WavePortType=Modal NumModes=1 Modes{Mode1{IntLine{(1, 0, 0) -> (1, 0.02, 0)} CharImp=Zpi RenormImp=50ohm}}
setups:
  Setup1: HfssDrivenAuto AutoSolverSetting=Balanced SaveAnyFields=false Type=Interpolating
    sweep Sweep: 4GHz to 8GHz, 501 points;
source amplitudes:
  2:1: 1W 0deg
  1:1: 0W 0deg
